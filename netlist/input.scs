// Design: MinhNT/tb_SRAM_CIM_4x4
simulator lang=spectre
global 0

// MinhNT/SRAM_6T/schematic
subckt SRAM_6T BL BL_INV GND VDD WL
    PM1 (Q Q_INV VDD VDD) gpdk090_pmos1v w=(120n) l=100n m=(1)*(1) simM=(1)*(1)
    PM0 (Q_INV Q VDD VDD) gpdk090_pmos1v w=(120n) l=100n m=(1)*(1) simM=(1)*(1)
    NM3 (Q Q_INV GND GND) gpdk090_nmos1v w=(240n) l=100n m=(1)*(1) simM=(1)*(1)
    NM2 (Q_INV Q GND GND) gpdk090_nmos1v w=(240n) l=100n m=(1)*(1) simM=(1)*(1)
    NM1 (BL WL Q GND) gpdk090_nmos1v w=(120n) l=100n m=(1)*(1) simM=(1)*(1)
    NM0 (Q_INV WL BL_INV GND) gpdk090_nmos1v w=(120n) l=100n m=(1)*(1) simM=(1)*(1)
ends SRAM_6T

// MinhNT/SRAM_CIM_4x4/schematic
subckt SRAM_CIM_4x4 BL0 BL1 BL2 BL3 BL_INV0 BL_INV1 BL_INV2 BL_INV3 GND VDD WL0 WL1 WL2 WL3
    I19 (BL0 BL_INV0 GND VDD WL3) SRAM_6T
    I30 (BL3 BL_INV3 GND VDD WL2) SRAM_6T
    I29 (BL3 BL_INV3 GND VDD WL1) SRAM_6T
    I31 (BL3 BL_INV3 GND VDD WL3) SRAM_6T
    I18 (BL0 BL_INV0 GND VDD WL2) SRAM_6T
    I28 (BL3 BL_INV3 GND VDD WL0) SRAM_6T
    I27 (BL2 BL_INV2 GND VDD WL3) SRAM_6T
    I26 (BL2 BL_INV2 GND VDD WL2) SRAM_6T
    I17 (BL0 BL_INV0 GND VDD WL1) SRAM_6T
    I25 (BL2 BL_INV2 GND VDD WL1) SRAM_6T
    I24 (BL2 BL_INV2 GND VDD WL0) SRAM_6T
    I23 (BL1 BL_INV1 GND VDD WL3) SRAM_6T
    I16 (BL0 BL_INV0 GND VDD WL0) SRAM_6T
    I22 (BL1 BL_INV1 GND VDD WL2) SRAM_6T
    I21 (BL1 BL_INV1 GND VDD WL1) SRAM_6T
    I20 (BL1 BL_INV1 GND VDD WL0) SRAM_6T
ends SRAM_CIM_4x4

// MinhNT/tb_SRAM_CIM_4x4/schematic
I0 (net16 net14 net12 net10 net2 net4 net6 net8 0 net21 net22 net23 net24 net25) SRAM_CIM_4x4
W7 (net12 net41 net27 0) relay vt1=400.0m vt2=600.0m ropen=1G rclosed=10
W6 (net16 net35 net29 0) relay vt1=400.0m vt2=600.0m ropen=1G rclosed=10
W5 (net14 net38 net28 0) relay vt1=400.0m vt2=600.0m ropen=1G rclosed=10
W4 (net10 net44 net26 0) relay vt1=400.0m vt2=600.0m ropen=1G rclosed=10
W3 (net8 net48 net20 0) relay vt1=400.0m vt2=600.0m ropen=1G rclosed=10
W0 (net2 net55 net17 0) relay vt1=400.0m vt2=600.0m ropen=1G rclosed=10
W2 (net6 net45 net19 0) relay vt1=400.0m vt2=600.0m ropen=1G rclosed=10
W1 (net4 net59 net18 0) relay vt1=400.0m vt2=600.0m ropen=1G rclosed=10
V0 (net21 0) vsource dc=1 type=dc
C7 (net10 0) capacitor c=25f
C6 (net12 0) capacitor c=25f
C5 (net16 0) capacitor c=25f
C4 (net14 0) capacitor c=25f
C3 (net6 0) capacitor c=25f
C2 (net8 0) capacitor c=25f
C0 (net2 0) capacitor c=25f
C1 (net4 0) capacitor c=25f
V34 (net29 0) vsource type=pulse val0=0 val1=1 period=30n delay=200.0p rise=100.0p fall=100.0p width=9.8n
V33 (net28 0) vsource type=pulse val0=0 val1=1 period=30n delay=200.0p rise=100.0p fall=100.0p width=9.8n
V32 (net27 0) vsource type=pulse val0=0 val1=1 period=30n delay=200.0p rise=100.0p fall=100.0p width=9.8n
V31 (net20 0) vsource type=pulse val0=0 val1=1 period=30n delay=200.0p rise=100.0p fall=100.0p width=9.8n
V30 (net19 0) vsource type=pulse val0=0 val1=1 period=30n delay=200.0p rise=100.0p fall=100.0p width=9.8n
V29 (net18 0) vsource type=pulse val0=0 val1=1 period=30n delay=200.0p rise=100.0p fall=100.0p width=9.8n
V25 (net44 0) vsource type=pulse val0=0 val1=1 period=30n delay=500.0p rise=100.0p fall=100.0p width=9.5n
V26 (net41 0) vsource type=pulse val0=0 val1=1 period=30n delay=1.5n rise=100.0p fall=100.0p width=8.5n
V27 (net38 0) vsource type=pulse val0=0 val1=1 period=30n delay=2.5n rise=100.0p fall=100.0p width=7.5n
V28 (net35 0) vsource type=pulse val0=0 val1=1 period=30n delay=3.5n rise=100.0p fall=100.0p width=6.5n
V9 (net26 0) vsource type=pulse val0=0 val1=1 period=30n delay=200.0p rise=100.0p fall=100.0p width=9.8n
V24 (net48 0) vsource type=pulse val0=1 val1=0 period=30n delay=500.0p rise=100.0p fall=100.0p width=4.1n
V4 (net17 0) vsource type=pulse val0=0 val1=1 period=30n delay=200.0p rise=100.0p fall=100.0p width=9.8n
V21 (net55 0) vsource type=pulse val0=1 val1=0 period=30n delay=3.5n rise=100.0p fall=100.0p width=1.1n
V22 (net59 0) vsource type=pulse val0=1 val1=0 period=30n delay=2.5n rise=100.0p fall=100.0p width=2.1n
V23 (net45 0) vsource type=pulse val0=1 val1=0 period=30n delay=1.5n rise=100.0p fall=100.0p width=3.1n
V8 (net25 0) vsource type=pwl wave=[ 0 0 3.55n 0 3.6n 1 4.4n 1 4.45n 0 10.95n 0 11n 250m 12n 250m 12.05n 0 20n 0 ]
V7 (net23 0) vsource type=pwl wave=[ 0 0 1.55n 0 1.6n 1 2.4n 1 2.45n 0 10.95n 0 11n 250m 12n 250m 12.05n 0 20n 0 ]
V6 (net24 0) vsource type=pwl wave=[ 0 0 2.55n 0 2.6n 1 3.4n 1 3.45n 0 10.95n 0 11n 250m 12n 250m 12.05n 0 20n 0 ]
V1 (net22 0) vsource type=pwl wave=[ 0 0 550p 0 600p 1 1.4n 1 1.45n 0 10.95n 0 11n 250m 12n 250m 12.05n 0 20n 0 ]
simulatorOptions options temp=27
tran tran stop=20n errpreset=conservative
saveOptions options save=all currents=all subcktprobelvl=2
