simulator( 'spectre )
design(	 "/home/buet/simulation/tb_SRAM_CIM_4x4/spectre/schematic/netlist/netlist")
resultsDir( "/home/buet/simulation/tb_SRAM_CIM_4x4/spectre/schematic" )
modelFile(
    '("/home/buet/cadence/gpdk090_v4.6/libs.oa22/gpdk090/../../models/spectre/gpdk090.scs" "NN")
)
saveOption( 'subcktprobelvl "2" )
saveOption( 'currents "all" )
saveOption( 'save "all" )
temp( 27 )
run()
modelFile(
    '("/home/buet/cadence/gpdk090_v4.6/libs.oa22/gpdk090/../../models/spectre/gpdk090.scs" "NN")
)
analysis('tran ?stop "20n"  ?errpreset "conservative"  )
envOption(
	'analysisOrder  list("tran")
)
run()
